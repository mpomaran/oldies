DIODA
.WIDTH IN=80 OUT=80
V1 1 0 0.7
D1 1 0 MOD1
.MODEL MOD1 D IS=3.5E-14 TT=5N CJO=3P BV=10 M=0.33 VJ=0.8 IBV=1.0E-5 RS=1
.DC V1 -10.3 0.8 0.1
.PRINT DC I(V1)
.OP
.OPTIONS NOPAGE
.PROBE
.END
