DIODAACH
.WIDTH IN=80 OUT=80
V1 1 0 SIN(0 10 50MEG 0 0)
D1 2 0 MOD1
R1 1 2 1K
.MODEL MOD1 D IS=3.5E-14 TT=5N CJO=3P BV=10 M=0.33 VJ=0.8 IBV=1.0E-5 RS=1
.TRAN 0.02N 40N
.OPTIONS LIMPTS 2001
.OP
.OPTIONS NOPAGE
.PROBE
.END
