MOS
.WIDTH IN=80 OUT=80
V1 1 0 DC 3
V2 2 0 DC 5
M 2 1 0 0 MOD1
.MODEL MOD1 NMOS VTO=1 KP=3E-5 LAMBDA=0.02 L=1U W=100U CGSO=4E-8
+CGDO=1E-8
.DC V2 0 10 0.05 V1 0 5 1
.OP
.OPTIONS NOPAGE
.PROBE
.END
