TRANSISTOR
.WIDTH IN=80 OUT=80
I1 0 1 40U
V2 3 0 5
V3 3 2
Q1 2 1 0 MOD1
.MODEL MOD1 NPN IS=1.0E-15 BF=100 NF=1 VAF=200 IKF=0.01 ISE=1.0E-12 NE=2 BR=0.1
+ NR=1 VAR=200 IKR=0.01 ISC=1.0E-13 NC=1.5  CJE
+ =2P VJE=0.6 MJE=0.33 TF=0.1N XTF=1 VTF=100 ITF=0.1 PTF=10 CJC=2P VJC=0.5 MJC=
+ 0.5 XCJC=0.7 TR=10N CJS=2P VJS=0.75 MJS=0.5 XTB=3.1500 EG=1.11 XTI=3 KF=0 AF=
+ 1 FC=0.5
.DC V2 0 10 0.05 I1 0 100U 20U
.OP
.OPTIONS NOPAGE
.PROBE
.END

