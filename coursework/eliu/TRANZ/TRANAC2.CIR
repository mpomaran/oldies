TRANSISTOR
.WIDTH IN=80 OUT=80
I1 0 1 7U
IG 1 0 AC 1U
V2 3 0 6.5
V3 3 2
Q1 2 1 0 MOD1
.MODEL MOD1 NPN IS=2.8E-14 BF=300 NF=1 VAF=60 IKF=0.05 ISE=2.8E-12 NE=2 BR=
+0.001 NR=1 VAR=200 RB=50 CJE=10P VJE=0.8 MJE=0.33 TF=0.5N CJC=2.5P
+TR=490U VJC=0.8 MJC=0.33
.AC DEC 10 10 10MEG
.PRINT AC I(V3)
.OP
.OPTIONS NOPAGE
.PROBE
.END
