MOSAC
.WIDTH IN=80 OUT=80
V1 1 0 DC 3
V2 5 0 DC 10
VG 1 2 AC 1M
RG 2 3 10K
RD 4 5 1K
M 4 3 0 0 MOD1
.MODEL MOD1 NMOS VTO=1 KP=3E-5 LAMBDA=0.02 L=1U W=100U CGSO=4E-8
+CGDO=1E-8
.AC DEC 10 10 10MEG
.OP
.OPTIONS NOPAGE
.PROBE
.END
