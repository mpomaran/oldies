PRZELACZANIE
.WIDTH IN=80 OUT=80
VG 1 0 PULSE(-10 10 0 0 0 0.5U 1U)
RG 1 2 10K
VC 4 0 10
RC 3 4 1K
CL 3 5 0.1N
RL 5 0 10K
Q1 3 2 0 MOD1
.MODEL MOD1 NPN IS=2.8E-14 BF=300 NF=1 VAF=60 IKF=0.05 ISE=2.8E-12 NE=2 BR=
+0.001 NR=1 VAR=200 RB=50 CJE=10P VJE=0.8 MJE=0.33 TF=0.5N CJC=2.5P
+TR=490U VJC=0.8 MJC=0.33
.TRAN 50N 4U
.OPTIONS NOPAGE
.PROBE
.END
