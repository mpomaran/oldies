MOSVT
.WIDTH IN=80 OUT=80
V1 1 0 DC 5
V2 2 0 DC 3
M 2 1 0 0 MOD1
.MODEL MOD1 NMOS TOX=1E-7 NSUB=4.0E15 LAMBDA=0.02 L=1U W=100U
+CGSO=4E-8 CGDO=1E-8 NSS=1.0E10
.DC V1 0 4 0.05 V2 0.5 5 4.5
.OP
.OPTIONS NOPAGE
.PROBE
.END
