MOSTR
.WIDTH IN=80 OUT=80
V1 1 0 DC 0
V2 5 0 DC 10
VG 2 1 PULSE(0 6 0.1U 0 0 0.2U 0.4U)
RG 2 3 10K
RD 4 5 1K
M 4 3 0 0 MOD1
.MODEL MOD1 NMOS VTO=1 KP=3E-5 LAMBDA=0.02 L=1U W=100U CGSO=4E-8
+CGDO=1E-8 TOX=0.1U
.TRAN 0.001U 0.9U
.OP
.OPTIONS NOPAGE
.PROBE
.END
